ADE simulation setup
Test ECE_482_Final_Project_top_level_1: ECE_482_Final_Project/top_level/schematic, simulator hspiceD
Run mode: Single Run, Sweeps and Corners
