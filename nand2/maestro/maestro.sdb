ADE simulation setup
Run mode: Single Run, Sweeps and Corners
Tests:
  ece482_final_project_nand2_1: ece482_final_project/nand2/schematic, simulator hspiceD
