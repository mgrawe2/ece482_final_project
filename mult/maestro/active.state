ADE simulation setup
Test ece482_final_project_mult_1: ece482_final_project/mult/av_extracted, simulator hspiceD
Run mode: Single Run, Sweeps and Corners
