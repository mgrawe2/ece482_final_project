ADE simulation setup
Test ece482_final_project_and2_1: ece482_final_project/and2/schematic, simulator hspiceD
Run mode: Single Run, Sweeps and Corners
