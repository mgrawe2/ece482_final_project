ADE simulation setup
Run mode: Single Run, Sweeps and Corners
Tests:
  ece482_final_project_half_adder_1: ece482_final_project/half_adder/av_extracted, simulator hspiceD
