ADE simulation setup
Test ece482_final_project_top_level_matthew_1: ece482_final_project/top_level_matthew/schematic, simulator hspiceD
Run mode: Single Run, Sweeps and Corners
