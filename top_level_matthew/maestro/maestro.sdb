ADE simulation setup
Run mode: Single Run, Sweeps and Corners
Tests:
  ece482_final_project_top_level_matthew_1: ece482_final_project/top_level_matthew/schematic, simulator hspiceD
