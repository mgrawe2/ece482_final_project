ADE simulation setup
Test ece482_final_project_full_adder_1: ece482_final_project/full_adder/av_extracted, simulator hspiceD
Run mode: Single Run, Sweeps and Corners
