ADE simulation setup
Run mode: Single Run, Sweeps and Corners
Tests:
  ece482_final_project_full_adder_1: ece482_final_project/full_adder/av_extracted, simulator hspiceD
