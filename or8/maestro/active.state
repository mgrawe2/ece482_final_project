ADE simulation setup
Test ECE_482_Final_Project_or8_1: ECE_482_Final_Project/or8/schematic, simulator hspiceD
Run mode: Single Run, Sweeps and Corners
