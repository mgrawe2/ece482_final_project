ADE simulation setup
Run mode: Single Run, Sweeps and Corners
Tests:
  ECE_482_Final_Project_or8_1: ECE_482_Final_Project/or8/schematic, simulator hspiceD
