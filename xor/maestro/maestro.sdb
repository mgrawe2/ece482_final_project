ADE simulation setup
Run mode: Single Run, Sweeps and Corners
Tests:
  ece482_final_project_xor_1: ece482_final_project/xor/av_extracted, simulator hspiceD
