ADE simulation setup
Run mode: Single Run, Sweeps and Corners
Tests:
  ece482_final_project_tl_prog_1: ece482_final_project/tl_prog/schematic, simulator hspiceD
