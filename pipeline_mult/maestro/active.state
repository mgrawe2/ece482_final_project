ADE simulation setup
Test ece482_final_project_pipeline_mult_1: ece482_final_project/pipeline_mult/schematic, simulator hspiceD
Run mode: Single Run, Sweeps and Corners
