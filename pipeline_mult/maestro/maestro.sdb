ADE simulation setup
Run mode: Single Run, Sweeps and Corners
Tests:
  ece482_final_project_pipeline_mult_1: ece482_final_project/pipeline_mult/av_extracted, simulator hspiceD
