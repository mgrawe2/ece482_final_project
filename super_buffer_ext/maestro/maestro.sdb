ADE simulation setup
Run mode: Single Run, Sweeps and Corners
Tests:
  super_buffer_ext_super_test_1: super_buffer_ext/super_buffer_ext/schematic, simulator hspiceD
