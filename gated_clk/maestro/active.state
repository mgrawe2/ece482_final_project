ADE simulation setup
Test ece482_final_project_gated_clk_1: ece482_final_project/gated_clk/schematic, simulator hspiceD
Run mode: Single Run, Sweeps and Corners
