ADE simulation setup
Test ECE_482_Final_Project_gated_clk_1: ECE_482_Final_Project/gated_clk/schematic, simulator hspiceD
