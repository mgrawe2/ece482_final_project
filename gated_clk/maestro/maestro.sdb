ADE simulation setup
Run mode: Single Run, Sweeps and Corners
Tests:
  ECE_482_Final_Project_gated_clk_1: ECE_482_Final_Project/gated_clk/schematic, simulator hspiceD
