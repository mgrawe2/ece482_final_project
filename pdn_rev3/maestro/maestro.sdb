ADE simulation setup
Run mode: Single Run, Sweeps and Corners
Tests:
  ece482_final_project_pdn_rev3_1: ece482_final_project/pdn_rev3/schematic, simulator hspiceD
