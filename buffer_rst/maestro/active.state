ADE simulation setup
Test ECE_482_Final_Project_buffer_rst_1: ECE_482_Final_Project/buffer_rst/schematic, simulator hspiceD
Run mode: Single Run, Sweeps and Corners
