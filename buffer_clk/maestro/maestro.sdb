ADE simulation setup
Run mode: Single Run, Sweeps and Corners
Tests:
  ECE_482_Final_Project_buffer_clk_1: ECE_482_Final_Project/buffer_clk/schematic, simulator hspiceD
